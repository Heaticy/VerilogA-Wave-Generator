// This file is generated by the VA_GEN .

`include "constants.vams"
`include "disciplines.vams"

module DSP_signtb(VDD, GND, CLK,   DIN, SEL, MODE, WL, EN);
	input VDD, GND, CLK ;
    electrical VDD, GND, CLK ;

    output [11:0] DIN ;
    electrical [11:0] DIN ;

    output  SEL ;
    electrical  SEL ;

    output  MODE ;
    electrical  MODE ;

    output [7:0] WL ;
    electrical [7:0] WL ;

    output [3:0] EN ;
    electrical [3:0] EN ;

    integer signal_DIN ;
    integer signal_SEL ;
    integer signal_MODE ;
    integer signal_WL ;
    integer signal_EN ;

    integer count_DIN ;
    integer count_SEL ;
    integer count_MODE ;
    integer count_WL ;
    integer count_EN ;

    integer wave_DIN [0:10];
    integer wave_SEL [0:10];
    integer wave_MODE [0:10];
    integer wave_WL [0:10];
    integer wave_EN [0:10];

	integer count;
	integer clock;
	integer flag_clk ;

    genvar i ;

//       ___                   __
//      /\_ \                 /\ \
//   ___\//\ \     ___     ___\ \ \/'\               __      __    ___
//  /'___\\ \ \   / __`\  /'___\ \ , <    _______  /'_ `\  /'__`\/' _ `\
// /\ \__/ \_\ \_/\ \L\ \/\ \__/\ \ \\`\ /\______\/\ \L\ \/\  __//\ \/\ \
// \ \____\/\____\ \____/\ \____\\ \_\ \_\/______/\ \____ \ \____\ \_\ \_\
//  \/____/\/____/\/___/  \/____/ \/_/\/_/         \/___L\ \/____/\/_/\/_/
//                                                   /\____/
//                                                   \_/__/

    // Clock-Generator
    analog begin
        @(initial_step)	begin

            count = 0 ;
            clock = 0 ;
            flag_clk = 0 ;
            signal_DIN = 0 ;
            signal_SEL = 0 ;
            signal_MODE = 0 ;
            signal_WL = 0 ;
            signal_EN = 0 ;

            count_DIN = 0 ;
            count_SEL = 0 ;
            count_MODE = 0 ;
            count_WL = 0 ;
            count_EN = 0 ;

            wave_DIN [0] = 17 ;
            wave_DIN [1] = 3 ;
            wave_DIN [2] = 256 ;
            wave_DIN [3] = 4 ;
            wave_DIN [4] = 0 ;
            wave_DIN [5] = 0 ;
            wave_DIN [6] = 0 ;
            wave_DIN [7] = 0 ;
            wave_DIN [8] = 0 ;
            wave_DIN [9] = 0 ;
            wave_DIN [10] = 0 ;

            wave_SEL [0] = 1 ;
            wave_SEL [1] = 1 ;
            wave_SEL [2] = 1 ;
            wave_SEL [3] = 1 ;
            wave_SEL [4] = 0 ;
            wave_SEL [5] = 0 ;
            wave_SEL [6] = 0 ;
            wave_SEL [7] = 0 ;
            wave_SEL [8] = 0 ;
            wave_SEL [9] = 0 ;
            wave_SEL [10] = 0 ;

            wave_MODE [0] = 1 ;
            wave_MODE [1] = 1 ;
            wave_MODE [2] = 1 ;
            wave_MODE [3] = 1 ;
            wave_MODE [4] = 0 ;
            wave_MODE [5] = 0 ;
            wave_MODE [6] = 0 ;
            wave_MODE [7] = 0 ;
            wave_MODE [8] = 0 ;
            wave_MODE [9] = 1 ;
            wave_MODE [10] = 0 ;

            wave_WL [0] = 1 ;
            wave_WL [1] = 2 ;
            wave_WL [2] = 4 ;
            wave_WL [3] = 8 ;
            wave_WL [4] = 1 ;
            wave_WL [5] = 2 ;
            wave_WL [6] = 4 ;
            wave_WL [7] = 8 ;
            wave_WL [8] = 0 ;
            wave_WL [9] = 16 ;
            wave_WL [10] = 16 ;

            wave_EN [0] = 0 ;
            wave_EN [1] = 0 ;
            wave_EN [2] = 0 ;
            wave_EN [3] = 0 ;
            wave_EN [4] = 0 ;
            wave_EN [5] = 1 ;
            wave_EN [6] = 2 ;
            wave_EN [7] = 4 ;
            wave_EN [8] = 8 ;
            wave_EN [9] = 0 ;
            wave_EN [10] = 0 ;

        end

        @( cross( V(CLK,GND)- V(VDD,GND), +1 ) ) begin
            clock = 1 ;
            count = count + 1 ;
            if(count >= 100 ) count = 0 ;
        end

        @( cross( clock - 1 , +1) )  begin
            if(clock != 0) clock = 0 ;
            flag_clk = 1 ;
        end

    end

//  __      __                                             ____
// /\ \  __/\ \                                           /\  _`\
// \ \ \/\ \ \ \     __     __  __     __    ____         \ \ \L\_\     __    ___
//  \ \ \ \ \ \ \  /'__`\  /\ \/\ \  /'__`\ /',__\  _______\ \ \L_L   /'__`\/' _ `\
//   \ \ \_/ \_\ \/\ \L\.\_\ \ \_/ |/\  __//\__, `\/\______\\ \ \/, \/\  __//\ \/\ \
//    \ `\___x___/\ \__/.\_\\ \___/ \ \____\/\____/\/______/ \ \____/\ \____\ \_\ \_\
//     '\/__//__/  \/__/\/_/ \/__/   \/____/\/___/            \/___/  \/____/\/_/\/_/

	// Waves-Generator
	analog begin

		@( cross( flag_clk - 1 , +1) )  begin
			flag_clk = 0 ;

            signal_DIN = wave_DIN[ count_DIN % 11 ] ;
            signal_SEL = wave_SEL[ count_SEL % 11 ] ;
            signal_MODE = wave_MODE[ count_MODE % 11 ] ;
            signal_WL = wave_WL[ count_WL % 11 ] ;
            signal_EN = wave_EN[ count_EN % 11 ] ;

            count_DIN = count_DIN + 1 ;
            count_SEL = count_SEL + 1 ;
            count_MODE = count_MODE + 1 ;
            count_WL = count_WL + 1 ;
            count_EN = count_EN + 1 ;

		end

	end

//                __                     __
//               /\ \__                 /\ \__
//   ___   __  __\ \ ,_\  _____   __  __\ \ ,_\
//  / __`\/\ \/\ \\ \ \/ /\ '__`\/\ \/\ \\ \ \/
// /\ \L\ \ \ \_\ \\ \ \_\ \ \L\ \ \ \_\ \\ \ \_
// \ \____/\ \____/ \ \__\\ \ ,__/\ \____/ \ \__\
//  \/___/  \/___/   \/__/ \ \ \/  \/___/   \/__/
//                          \ \_\
//                           \/_/

	// Signal-Output
	analog begin

        for(i=0; i<12; i=i+1) begin
            V( DIN[i] ) <+ transition( V(VDD,GND)*((signal_DIN&(1<<i))>>i), 0, 0 ) ;
        end

        for(i=0; i<1; i=i+1) begin
            V( SEL ) <+ transition( V(VDD,GND)*((signal_SEL&(1<<i))>>i), 0, 0 ) ;
        end

        for(i=0; i<1; i=i+1) begin
            V( MODE ) <+ transition( V(VDD,GND)*((signal_MODE&(1<<i))>>i), 0, 0 ) ;
        end

        for(i=0; i<8; i=i+1) begin
            V( WL[i] ) <+ transition( V(VDD,GND)*((signal_WL&(1<<i))>>i), 0, 0 ) ;
        end

        for(i=0; i<4; i=i+1) begin
            V( EN[i] ) <+ transition( V(VDD,GND)*((signal_EN&(1<<i))>>i), 0, 0 ) ;
        end

	end

endmodule
